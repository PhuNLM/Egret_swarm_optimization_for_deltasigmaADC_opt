(procedure khoitao()
simulator( 'spectre )
design(	 "/home/disk/simulation/SIM_IC61/Comp_run/spectre/schematic/netlist/netlist")
resultsDir( "/home/disk/simulation/SIM_IC61/Comp_run/spectre/schematic" )
modelFile(
    '("/home/hoangtrang/Thu_vien_PDK/PDK_CRN65LP_v1.7a_Official_IC61_20120914_all/PDK_CRN65LP_v1.7a_Official_IC61_20120914/tsmcN65/../models/spectre/toplevel.scs" "tt_lib")
)

fin=infile("./Comp_para.txt")
fscanf(fin "\n%s" LM12_1_var	)
fscanf(fin "\n%s" LM12_2_var	)
fscanf(fin "\n%s" LM12_3_var	)
fscanf(fin "\n%s" LM12_4_var	)
fscanf(fin "\n%s" LM12_5_var	)
fscanf(fin "\n%s" LM12_6_var	)
fscanf(fin "\n%s" LM12_7_var	)
fscanf(fin "\n%s" LM12_8_var	)
fscanf(fin "\n%s" LM34_1_var	)
fscanf(fin "\n%s" LM34_2_var	)
fscanf(fin "\n%s" LM34_3_var	)
fscanf(fin "\n%s" LM34_4_var	)
fscanf(fin "\n%s" LM34_5_var	)
fscanf(fin "\n%s" LM34_6_var	)
fscanf(fin "\n%s" LM34_7_var	)
fscanf(fin "\n%s" LM34_8_var	)
fscanf(fin "\n%s" LM56_1_var	)
fscanf(fin "\n%s" LM56_2_var	)
fscanf(fin "\n%s" LM56_3_var	)
fscanf(fin "\n%s" LM56_4_var	)
fscanf(fin "\n%s" LM56_5_var	)
fscanf(fin "\n%s" LM56_6_var	)
fscanf(fin "\n%s" LM56_7_var	)
fscanf(fin "\n%s" LM56_8_var	)
fscanf(fin "\n%s" LM7_1_var	)
fscanf(fin "\n%s" LM7_2_var	)
fscanf(fin "\n%s" LM7_3_var	)
fscanf(fin "\n%s" LM7_4_var	)
fscanf(fin "\n%s" LM7_5_var	)
fscanf(fin "\n%s" LM7_6_var	)
fscanf(fin "\n%s" LM7_7_var	)
fscanf(fin "\n%s" LM7_8_var	)
fscanf(fin "\n%s" LS_1_var	)
fscanf(fin "\n%s" LS_2_var	)
fscanf(fin "\n%s" LS_3_var	)
fscanf(fin "\n%s" LS_4_var	)
fscanf(fin "\n%s" LS_5_var	)
fscanf(fin "\n%s" LS_6_var	)
fscanf(fin "\n%s" LS_7_var	)
fscanf(fin "\n%s" LS_8_var	)
fscanf(fin "\n%s" WM12_1_var	)
fscanf(fin "\n%s" WM12_2_var	)
fscanf(fin "\n%s" WM12_3_var	)
fscanf(fin "\n%s" WM12_4_var	)
fscanf(fin "\n%s" WM12_5_var	)
fscanf(fin "\n%s" WM12_6_var	)
fscanf(fin "\n%s" WM12_7_var	)
fscanf(fin "\n%s" WM12_8_var	)
fscanf(fin "\n%s" WM34_1_var	)
fscanf(fin "\n%s" WM34_2_var	)
fscanf(fin "\n%s" WM34_3_var	)
fscanf(fin "\n%s" WM34_4_var	)
fscanf(fin "\n%s" WM34_5_var	)
fscanf(fin "\n%s" WM34_6_var	)
fscanf(fin "\n%s" WM34_7_var	)
fscanf(fin "\n%s" WM34_8_var	)
fscanf(fin "\n%s" WM56_1_var	)
fscanf(fin "\n%s" WM56_2_var	)
fscanf(fin "\n%s" WM56_3_var	)
fscanf(fin "\n%s" WM56_4_var	)
fscanf(fin "\n%s" WM56_5_var	)
fscanf(fin "\n%s" WM56_6_var	)
fscanf(fin "\n%s" WM56_7_var	)
fscanf(fin "\n%s" WM56_8_var	)
fscanf(fin "\n%s" WM7_1_var	)
fscanf(fin "\n%s" WM7_2_var	)
fscanf(fin "\n%s" WM7_3_var	)
fscanf(fin "\n%s" WM7_4_var	)
fscanf(fin "\n%s" WM7_5_var	)
fscanf(fin "\n%s" WM7_6_var	)
fscanf(fin "\n%s" WM7_7_var	)
fscanf(fin "\n%s" WM7_8_var	)
fscanf(fin "\n%s" WS_1_var	)
fscanf(fin "\n%s" WS_2_var	)
fscanf(fin "\n%s" WS_3_var	)
fscanf(fin "\n%s" WS_4_var	)
fscanf(fin "\n%s" WS_5_var	)
fscanf(fin "\n%s" WS_6_var	)
fscanf(fin "\n%s" WS_7_var	)
fscanf(fin "\n%s" WS_8_var	)
close(fin)
)

(procedure chay()

analysis('dc ?saveOppoint t  )
analysis('tran ?stop "30n"  )

desVar(	  "AMP" "1.2"	)
desVar(	  "FREQ" "100M"	)
desVar(	  "LM12_1" LM12_1_var	)
desVar(	  "LM12_2" LM12_2_var	)
desVar(	  "LM12_3" LM12_3_var	)
desVar(	  "LM12_4" LM12_4_var	)
desVar(	  "LM12_5" LM12_5_var	)
desVar(	  "LM12_6" LM12_6_var	)
desVar(	  "LM12_7" LM12_7_var	)
desVar(	  "LM12_8" LM12_8_var	)
desVar(	  "LM34_1" LM34_1_var	)
desVar(	  "LM34_2" LM34_2_var	)
desVar(	  "LM34_3" LM34_3_var	)
desVar(	  "LM34_4" LM34_4_var	)
desVar(	  "LM34_5" LM34_5_var	)
desVar(	  "LM34_6" LM34_6_var	)
desVar(	  "LM34_7" LM34_7_var	)
desVar(	  "LM34_8" LM34_8_var	)
desVar(	  "LM56_1" LM56_1_var	)
desVar(	  "LM56_2" LM56_2_var	)
desVar(	  "LM56_3" LM56_3_var	)
desVar(	  "LM56_4" LM56_4_var	)
desVar(	  "LM56_5" LM56_5_var	)
desVar(	  "LM56_6" LM56_6_var	)
desVar(	  "LM56_7" LM56_7_var	)
desVar(	  "LM56_8" LM56_8_var	)
desVar(	  "LM7_1" LM7_1_var	)
desVar(	  "LM7_2" LM7_2_var	)
desVar(	  "LM7_3" LM7_3_var	)
desVar(	  "LM7_4" LM7_4_var	)
desVar(	  "LM7_5" LM7_5_var	)
desVar(	  "LM7_6" LM7_6_var	)
desVar(	  "LM7_7" LM7_7_var	)
desVar(	  "LM7_8" LM7_8_var	)
desVar(	  "LS_1" LS_1_var	)
desVar(	  "LS_2" LS_2_var	)
desVar(	  "LS_3" LS_3_var	)
desVar(	  "LS_4" LS_4_var	)
desVar(	  "LS_5" LS_5_var	)
desVar(	  "LS_6" LS_6_var	)
desVar(	  "LS_7" LS_7_var	)
desVar(	  "LS_8" LS_8_var	)
desVar(	  "pe" "2.85n"	)
desVar(	  "pw" "1.425n"	)
desVar(	  "VDD" "2.4"	)
desVar(	  "VREF" "1.2"	)
desVar(	  "WM12_1" WM12_1_var	)
desVar(	  "WM12_2" WM12_2_var	)
desVar(	  "WM12_3" WM12_3_var	)
desVar(	  "WM12_4" WM12_4_var	)
desVar(	  "WM12_5" WM12_5_var	)
desVar(	  "WM12_6" WM12_6_var	)
desVar(	  "WM12_7" WM12_7_var	)
desVar(	  "WM12_8" WM12_8_var	)
desVar(	  "WM34_1" WM34_1_var	)
desVar(	  "WM34_2" WM34_2_var	)
desVar(	  "WM34_3" WM34_3_var	)
desVar(	  "WM34_4" WM34_4_var	)
desVar(	  "WM34_5" WM34_5_var	)
desVar(	  "WM34_6" WM34_6_var	)
desVar(	  "WM34_7" WM34_7_var	)
desVar(	  "WM34_8" WM34_8_var	)
desVar(	  "WM56_1" WM56_1_var	)
desVar(	  "WM56_2" WM56_2_var	)
desVar(	  "WM56_3" WM56_3_var	)
desVar(	  "WM56_4" WM56_4_var	)
desVar(	  "WM56_5" WM56_5_var	)
desVar(	  "WM56_6" WM56_6_var	)
desVar(	  "WM56_7" WM56_7_var	)
desVar(	  "WM56_8" WM56_8_var	)
desVar(	  "WM7_1" WM7_1_var	)
desVar(	  "WM7_2" WM7_2_var	)
desVar(	  "WM7_3" WM7_3_var	)
desVar(	  "WM7_4" WM7_4_var	)
desVar(	  "WM7_5" WM7_5_var	)
desVar(	  "WM7_6" WM7_6_var	)
desVar(	  "WM7_7" WM7_7_var	)
desVar(	  "WM7_8" WM7_8_var	)
desVar(	  "WS_1" WS_1_var	)
desVar(	  "WS_2" WS_2_var	)
desVar(	  "WS_3" WS_3_var	)
desVar(	  "WS_4" WS_4_var	)
desVar(	  "WS_5" WS_5_var	)
desVar(	  "WS_6" WS_6_var	)
desVar(	  "WS_7" WS_7_var	)
desVar(	  "WS_8" WS_8_var	)
envOption(
	'analysisOrder  list("tran" "dc")
)
saveOption( 'currents "all" )
saveOption( 'pwr "all" )
saveOption( 'save "all" )
temp( 27 )
run()

C1_pwr = average(getData("I0:pwr" ?result "tran"))
;plot( C1_pwr ?expr '( "C1_pwr" ) )

C2_pwr = average(getData("I1:pwr" ?result "tran"))
;plot( C2_pwr ?expr '( "C2_pwr" ) )

C3_pwr = average(getData("I2:pwr" ?result "tran"))
;plot( C3_pwr ?expr '( "C3_pwr" ) )

C4_pwr = average(getData("I3:pwr" ?result "tran"))
;plot( C4_pwr ?expr '( "C4_pwr" ) )

C5_pwr = average(getData("I8:pwr" ?result "tran"))
;plot( C5_pwr ?expr '( "C5_pwr" ) )

C6_pwr = average(getData("I9:pwr" ?result "tran"))
;plot( C6_pwr ?expr '( "C6_pwr" ) )

C7_pwr = average(getData("I10:pwr" ?result "tran"))
;plot( C7_pwr ?expr '( "C7_pwr" ) )

C8_pwr = average(getData("I11:pwr" ?result "tran"))
;plot( C8_pwr ?expr '( "C8_pwr" ) )

selectResult( 'tran )
plot(getData("/CLK"))
plot(getData("/VIN1"))
plot(getData("/VOUT2_1"))
plot(getData("/VOUT2_2"))
plot(getData("/VOUT2_3"))
plot(getData("/VOUT2_4"))
plot(getData("/VOUT2_5"))
plot(getData("/VOUT2_7"))
plot(getData("/VOUT2_8"))
plot(getData("/VOUT2_6"))

avr_delay_1 = (delay(?wf1 VT("/CLK"), ?value1 0.6, ?edge1 "rising", ?nth1 3, ?td1 0.0, ?wf2 VT("/VOUT2_1"), ?value2 1.2, ?edge2 "falling", ?nth2 1,  ?td2 nil , ?stop nil, ?multiple nil) + delay(?wf1 VT("/CLK"), ?value1 0.6, ?edge1 "falling", ?nth1 3, ?td1 0.0, ?wf2 VT("/VOUT2_1"), ?value2 1.2, ?edge2 "rising", ?nth2 1,  ?td2 nil , ?stop nil, ?multiple nil))/2

avr_delay_2 = (delay(?wf1 VT("/CLK"), ?value1 0.6, ?edge1 "rising", ?nth1 3, ?td1 0.0, ?wf2 VT("/VOUT2_2"), ?value2 1.2, ?edge2 "falling", ?nth2 1,  ?td2 nil , ?stop nil, ?multiple nil) + delay(?wf1 VT("/CLK"), ?value1 0.6, ?edge1 "falling", ?nth1 3, ?td1 0.0, ?wf2 VT("/VOUT2_2"), ?value2 1.2, ?edge2 "rising", ?nth2 1,  ?td2 nil , ?stop nil, ?multiple nil))/2

avr_delay_3 = (delay(?wf1 VT("/CLK"), ?value1 0.6, ?edge1 "rising", ?nth1 3, ?td1 0.0, ?wf2 VT("/VOUT2_3"), ?value2 1.2, ?edge2 "falling", ?nth2 1,  ?td2 nil , ?stop nil, ?multiple nil) + delay(?wf1 VT("/CLK"), ?value1 0.6, ?edge1 "falling", ?nth1 3, ?td1 0.0, ?wf2 VT("/VOUT2_3"), ?value2 1.2, ?edge2 "rising", ?nth2 1,  ?td2 nil , ?stop nil, ?multiple nil))/2

avr_delay_4 = (delay(?wf1 VT("/CLK"), ?value1 0.6, ?edge1 "rising", ?nth1 3, ?td1 0.0, ?wf2 VT("/VOUT2_4"), ?value2 1.2, ?edge2 "falling", ?nth2 1,  ?td2 nil , ?stop nil, ?multiple nil) + delay(?wf1 VT("/CLK"), ?value1 0.6, ?edge1 "falling", ?nth1 3, ?td1 0.0, ?wf2 VT("/VOUT2_4"), ?value2 1.2, ?edge2 "rising", ?nth2 1,  ?td2 nil , ?stop nil, ?multiple nil))/2

avr_delay_5 = (delay(?wf1 VT("/CLK"), ?value1 0.6, ?edge1 "rising", ?nth1 3, ?td1 0.0, ?wf2 VT("/VOUT2_5"), ?value2 1.2, ?edge2 "falling", ?nth2 1,  ?td2 nil , ?stop nil, ?multiple nil) + delay(?wf1 VT("/CLK"), ?value1 0.6, ?edge1 "falling", ?nth1 3, ?td1 0.0, ?wf2 VT("/VOUT2_5"), ?value2 1.2, ?edge2 "rising", ?nth2 1,  ?td2 nil , ?stop nil, ?multiple nil))/2

avr_delay_6 = (delay(?wf1 VT("/CLK"), ?value1 0.6, ?edge1 "rising", ?nth1 3, ?td1 0.0, ?wf2 VT("/VOUT2_6"), ?value2 1.2, ?edge2 "falling", ?nth2 1,  ?td2 nil , ?stop nil, ?multiple nil) + delay(?wf1 VT("/CLK"), ?value1 0.6, ?edge1 "falling", ?nth1 3, ?td1 0.0, ?wf2 VT("/VOUT2_6"), ?value2 1.2, ?edge2 "rising", ?nth2 1,  ?td2 nil , ?stop nil, ?multiple nil))/2

avr_delay_7 = (delay(?wf1 VT("/CLK"), ?value1 0.6, ?edge1 "rising", ?nth1 3, ?td1 0.0, ?wf2 VT("/VOUT2_7"), ?value2 1.2, ?edge2 "falling", ?nth2 1,  ?td2 nil , ?stop nil, ?multiple nil) + delay(?wf1 VT("/CLK"), ?value1 0.6, ?edge1 "falling", ?nth1 3, ?td1 0.0, ?wf2 VT("/VOUT2_7"), ?value2 1.2, ?edge2 "rising", ?nth2 1,  ?td2 nil , ?stop nil, ?multiple nil))/2

avr_delay_8 = (delay(?wf1 VT("/CLK"), ?value1 0.6, ?edge1 "rising", ?nth1 3, ?td1 0.0, ?wf2 VT("/VOUT2_8"), ?value2 1.2, ?edge2 "falling", ?nth2 1,  ?td2 nil , ?stop nil, ?multiple nil) + delay(?wf1 VT("/CLK"), ?value1 0.6, ?edge1 "falling", ?nth1 3, ?td1 0.0, ?wf2 VT("/VOUT2_8"), ?value2 1.2, ?edge2 "rising", ?nth2 1,  ?td2 nil , ?stop nil, ?multiple nil))/2

fileresult=outfile("./Result.txt")
  fprintf(fileresult "%1.15f\r" avr_delay_1)
  fprintf(fileresult "%1.15f\r" avr_delay_2)
  fprintf(fileresult "%1.15f\r" avr_delay_3)
  fprintf(fileresult "%1.15f\r" avr_delay_4)
  fprintf(fileresult "%1.15f\r" avr_delay_5)
  fprintf(fileresult "%1.15f\r" avr_delay_6)
  fprintf(fileresult "%1.15f\r" avr_delay_7)
  fprintf(fileresult "%1.15f\r" avr_delay_8)
  fprintf(fileresult "%1.15f\r" C1_pwr)
  fprintf(fileresult "%1.15f\r" C2_pwr)
  fprintf(fileresult "%1.15f\r" C3_pwr)
  fprintf(fileresult "%1.15f\r" C4_pwr)
  fprintf(fileresult "%1.15f\r" C5_pwr)
  fprintf(fileresult "%1.15f\r" C6_pwr)
  fprintf(fileresult "%1.15f\r" C7_pwr)
  fprintf(fileresult "%1.15f\r" C8_pwr)
close(fileresult)
)

khoitao()
chay()
;exit
