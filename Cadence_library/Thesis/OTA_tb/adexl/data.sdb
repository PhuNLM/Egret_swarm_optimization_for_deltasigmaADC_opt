ADE simulation setup
Run mode: Single Run, Sweeps and Corners
Tests:
  Thesis:OTA_tb:1: Thesis/OTA_tb/schematic, simulator spectre
    Outputs: gain; phase; phaseMargin; GBW; Gain; MN1_1; MN2_1; MN3_1; MN4_1; MN5_1; MN7_1; MN8_1; MN9_1; MP1_1; MP2_1; MP5_1; MP6_1; MP8_1
Global variables:
  Cc_1 = 600f
  LM12345_1 = 240n,520n
  LM68_1 = LM12345_1
  LM79_1 = LM12345_1
  LMN8_1 = LM12345_1
  LMP1_1 = LM12345_1
  LMP2_1 = LM12345_1
  LMP5_1 = LM12345_1
  WM12345_1 = 1u,15u,10u
  WM68_1 = 65u:-15u:20u
  WM79_1 = 30u:-10u:5u
  WMN8_1 = 200u,80u
  WMP1_1 = 30u:-10u:5u
  WMP2_1 = 30u:-10u:5u
  WMP5_1 = 100u,20u
Corners:
  TTNN (off): temperature=25
  FFHH (off): temperature=135
  FFHL (off): temperature=-40
  SSLL (off): temperature=-40
  SSLH (off): temperature=135
Specs:
  Thesis:OTA_tb:1 / MN2_1: range 1.5 to 2.5
  Thesis:OTA_tb:1 / MN3_1: range 1.5 to 2.5
  Thesis:OTA_tb:1 / MN4_1: range 1.5 to 2.5
  Thesis:OTA_tb:1 / MN5_1: range 1.5 to 2.5
  Thesis:OTA_tb:1 / MN7_1: range 1.5 to 2.5
  Thesis:OTA_tb:1 / MN8_1: range 1.5 to 2.5
  Thesis:OTA_tb:1 / MN9_1: range 1.5 to 2.5
  Thesis:OTA_tb:1 / MP1_1: range 1.5 to 2.5
  Thesis:OTA_tb:1 / MP2_1: range 1.5 to 2.5
  Thesis:OTA_tb:1 / MP5_1: range 1.5 to 2.5
  Thesis:OTA_tb:1 / MP6_1: range 1.5 to 2.5
  Thesis:OTA_tb:1 / MP8_1: range 1.5 to 2.5
  Thesis:OTA_tb:1 / MN1_1: range 1.5 to 2.5
