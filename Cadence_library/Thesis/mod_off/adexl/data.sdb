ADE simulation setup
Run mode: Single Run, Sweeps and Corners
Tests:
  Thesis:mod_off:1: Thesis/mod_off/schematic, simulator spectre
    Outputs: psd; enob; snr
Global variables:
  C = 820p
  Cc_1 = 528.4f
  F = 20K
  LM12345_1 = 520n
  LM68_1 = 520n
  LM79_1 = 520n
  LMN8_1 = 520n
  LMP1_1 = 520n
  LMP2_1 = 520n
  LMP5_1 = 520n
  OSR = 128
  R = 1k
  WM12345_1 = 2.8u
  WM68_1 = 15u
  WM79_1 = 9.732u
  WMN8_1 = 80u
  WMP1_1 = 9.732u
  WMP2_1 = 9.732u
  WMP5_1 = 37u
Corners:
  TTNN: temperature=25
  FFHH: temperature=135
  FFHL: temperature=-40
  SSLL: temperature=-40
  SSLH: temperature=135
