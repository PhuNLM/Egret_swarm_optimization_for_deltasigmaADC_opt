ADE simulation setup
Run mode: Single Run, Sweeps and Corners
Tests:
  Thesis:comp_b:1: Thesis/comp_b/schematic, simulator spectre
    Outputs: OP_LS1; OP_LS2; OP_LS3; OP_LS4
Global variables:
  LM12 = 60n
  LM34 = 60n
  LM56 = 60n
  LM7 = 60n
  LS = 420n:-60n:60n
  WM12 = 180n
  WM34 = 180n
  WM56 = 180n
  WM7 = 180n
  WS = 5u:-180n:120n
