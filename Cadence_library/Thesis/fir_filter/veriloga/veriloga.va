// VerilogA for Thesis, fir_filter, veriloga

`include "constants.vams"
`include "disciplines.vams"

module fir_filter(vin, vout, vclk);
input vin, vclk;
output vout;
electrical vin, vout, vclk;

parameter integer TAPS = 255;
parameter real vtrans_clk = 0.2;
parameter real tdel = 1p from [0:inf);
parameter real trise = 1p from [0:inf);
parameter real tfall = 1p from [0:inf);

// H s b lc FIR (copy t file txt bng script)
parameter real coeff[0:254] = [-2.9e-05, 4.5e-05, -6.1e-05, 7.3e-05, -8.1e-05, 8e-05, -7.1e-05, 5.3e-05, -2.4e-05, -1.2e-05, 5.5e-05, -9.9e-05, 0.000142, -0.000177, 0.000201, -0.000209, 0.000197, -0.000164, 0.00011, -3.7e-05, -5e-05, 0.000144, -0.000238, 0.000321, -0.000384, 0.00042, -0.00042, 0.00038, -0.000299, 0.000181, -3.2e-05, -0.000138, 0.000314, -0.000481, 0.000621, -0.000719, 0.000762, -0.000738, 0.000644, -0.00048, 0.000256, 1.4e-05, -0.00031, 0.000606, -0.000875, 0.00109, -0.001227, 0.001264, -0.001189, 0.000999, -0.000702, 0.000314, 0.000136, -0.000614, 0.001078, -0.001484, 0.001791, -0.001963, 0.001971, -0.001803, 0.001458, -0.000954, 0.000323, 0.000388, -0.001122, 0.001814, -0.002398, 0.002814, -0.00301, 0.002951, -0.002624, 0.002036, -0.001221, 0.000233, 0.000852, -0.001945, 0.002949, -0.003766, 0.00431, -0.00451, 0.004324, -0.003737, 0.002771, -0.001482, -3.9e-05, 0.001676, -0.003292, 0.004742, -0.005884, 0.006592, -0.006769, 0.006356, -0.005341, 0.003763, -0.001716, -0.00066, 0.003184, -0.005647, 0.007825, -0.009501, 0.010482, -0.010615, 0.009807, -0.008035, 0.005353, -0.001901, -0.002105, 0.006382, -0.01059, 0.01436, -0.017312, 0.019084, -0.01936, 0.017893, -0.014527, 0.009213, -0.00202, -0.006862, 0.017133, -0.02839, 0.040151, -0.051881, 0.063023, -0.073032, 0.081406, -0.087717, 0.09164, 0.907029, 0.09164, -0.087717, 0.081406, -0.073032, 0.063023, -0.051881, 0.040151, -0.02839, 0.017133, -0.006862, -0.00202, 0.009213, -0.014527, 0.017893, -0.01936, 0.019084, -0.017312, 0.01436, -0.01059, 0.006382, -0.002105, -0.001901, 0.005353, -0.008035, 0.009807, -0.010615, 0.010482, -0.009501, 0.007825, -0.005647, 0.003184, -0.00066, -0.001716, 0.003763, -0.005341, 0.006356, -0.006769, 0.006592, -0.005884, 0.004742, -0.003292, 0.001676, -3.9e-05, -0.001482, 0.002771, -0.003737, 0.004324, -0.00451, 0.00431, -0.003766, 0.002949, -0.001945, 0.000852, 0.000233, -0.001221, 0.002036, -0.002624, 0.002951, -0.00301, 0.002814, -0.002398, 0.001814, -0.001122, 0.000388, 0.000323, -0.000954, 0.001458, -0.001803, 0.001971, -0.001963, 0.001791, -0.001484, 0.001078, -0.000614, 0.000136, 0.000314, -0.000702, 0.000999, -0.001189, 0.001264, -0.001227, 0.00109, -0.000875, 0.000606, -0.00031, 1.4e-05, 0.000256, -0.00048, 0.000644, -0.000738, 0.000762, -0.000719, 0.000621, -0.000481, 0.000314, -0.000138, -3.2e-05, 0.000181, -0.000299, 0.00038, -0.00042, 0.00042, -0.000384, 0.000321, -0.000238, 0.000144, -5e-05, -3.7e-05, 0.00011, -0.000164, 0.000197, -0.000209, 0.000201, -0.000177, 0.000142, -9.9e-05, 5.5e-05, -1.2e-05, -2.4e-05, 5.3e-05, -7.1e-05, 8e-05, -8.1e-05, 7.3e-05, -6.1e-05, 4.5e-05, -2.9e-05];

real samples[0:254]; // lu lch s tn hiu vo
real vout_val;
integer i, j;

analog begin
   @(initial_step) begin
      for (i = 0; i < TAPS; i = i + 1)
         samples[i] = 0.0;
      vout_val = 0.0;
   end

   @(cross(V(vclk) - vtrans_clk, 1.0)) begin
      // Shift mu c
      for (i = TAPS-1; i > 0; i = i - 1)
         samples[i] = samples[i-1];
      samples[0] = V(vin);

      // Tnh tch chp FIR
      vout_val = 0.0;
      for (j = 0; j < TAPS; j = j + 1)
         vout_val = vout_val + coeff[j]*samples[j];
   end

   V(vout) <+ transition(vout_val, tdel, trise, tfall);
end
endmodule
