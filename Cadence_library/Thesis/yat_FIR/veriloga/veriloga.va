// VerilogA for Thesis, yat_FIR, veriloga

`include "constants.vams"
`include "disciplines.vams"

module yat_FIR(x,clk,y,VDD,VSS);

electrical x,clk,y,VDD,VSS; // I/O and supply ports(VDD and VSS)

integer F_SIZE = 255; // Number of filter taps

real x_d [F_SIZE-1:0];  // Filter flip flops
real coeff[F_SIZE-1:0]; // Filter coefficients
real aux;
parameter trans = 15.625p; // sets transition

integer k,fd,n;
genvar i;

analog initial begin

    fd = $fopen("/home/hoangtrang/Desktop/FIR_coefficients.txt","r"); // Coefficients file
    n = 0;

    for(k=0;k<F_SIZE;k=k+1) begin
        $fscanf(fd,"%f\n",coeff[n]); // Load coefficients to array
        n = n+1;
    end

    for(k=0;k<F_SIZE;k=k+1) begin
        x_d[k] = 0; // Initialize array
    end
end

analog begin

    //posedge detection
    @(cross( V(clk) - (V(VDD)/2),1,10p) ) begin

        aux = 0;
        for(i=0;i<255;i=i+1) begin
            aux = aux + x_d[i]*coeff[i]; // Multiply accumulate
        end

        x_d[0] = V(x,VSS); // insert the input at first flip flop
        for(i=255-2;i>=0;i=i-1) begin
            x_d[i+1] = x_d[i]; // shift the flip flops value
        end
    end

        // Node y voltage receives value of "aux" with transition "trans"
    V(y) <+ transition(aux,0,trans);

end
endmodule
