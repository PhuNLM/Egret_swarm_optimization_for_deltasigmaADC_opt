ADE simulation setup
Run mode: Single Run, Sweeps and Corners
Tests:
  Thesis:comp_bound:1: Thesis/comp_bound/schematic, simulator spectre
    Outputs: OP_LS1; OP_LS2; OP_LS3; OP_LS4
Global variables:
  LM12 = 60n
  LM34_1 = 60n
  LM56_1 = 60n
  LM7_1 = 60n
  LS_1 = 420n:-60n:60n
  WM12_1 = 180n
  WM34_1 = 180n
  WM56_1 = 180n
  WM7_1 = 180n
  WS_1 = 3u,-180n,120u
  LM34 = 60n
  LM56 = 60n
  LM7 = 60n
  LS = 420n:-60n:60n
  WM12 = 180n
  WM34 = 180n
  WM56 = 180n
  WM7 = 180n
  WS = 3u,-180n,120u
  LM12_1 = 60n
Specs:
  Thesis:comp_bound:1 / OP_LS1: range 1 to 3
  Thesis:comp_bound:1 / OP_LS2: range 1 to 3
  Thesis:comp_bound:1 / OP_LS3: range 1 to 3
  Thesis:comp_bound:1 / OP_LS4: range 1 to 3
