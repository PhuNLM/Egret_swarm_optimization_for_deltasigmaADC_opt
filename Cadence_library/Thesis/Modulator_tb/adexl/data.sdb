ADE simulation setup
Run mode: Single Run, Sweeps and Corners
Tests:
  Thesis:Modulator:1: Thesis/Modulator/schematic, simulator spectre
    Outputs: enob; snr
Global variables:
  C = 10n
  R = 1k
  OSR = 512,1024
  F = 10k,15k,20k
