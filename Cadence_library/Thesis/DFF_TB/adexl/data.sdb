ADE simulation setup
Run mode: Single Run, Sweeps and Corners
Tests:
  Thesis:DFF:1: Thesis/DFF/schematic, simulator spectre
    Outputs: Q_riseTime; Qn_riseTime; Q_fallTime; Qn_fallTime
Corners:
  model folders: /home/hoangtrang/Thu_vien_PDK/PDK_CRN65LP_v1.7a_Official_IC61_20120914_all/PDK_CRN65LP_v1.7a_Official_IC61_20120914/models/spectre
  FFHL: temperature=-40; toplevel.scs[tt_lib]
  FFHH: temperature=125; toplevel.scs[tt_lib]
