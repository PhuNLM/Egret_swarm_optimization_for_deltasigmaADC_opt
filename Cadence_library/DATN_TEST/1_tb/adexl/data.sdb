ADE simulation setup
Run mode: Single Run, Sweeps and Corners
Tests:
  20khz: DATN_TEST/1/schematic, simulator spectre
    Outputs: enob_blackman; snr_blackman; enob_rect; snr_rect
  10khz: DATN_TEST/1/schematic, simulator spectre
    Outputs: enob_rect; enob_blackman; snr_blackman; in
Global variables:
  C = 10n
  R = 1k
  F = 19375,20000
  Gain = 450
