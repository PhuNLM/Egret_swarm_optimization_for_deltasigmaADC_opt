(procedure khoitao()
simulator( 'spectre )
design(	 "/home/disk/simulation/SIM_IC61/ota_op/spectre/schematic/netlist/netlist")
resultsDir( "/home/disk/simulation/SIM_IC61/ota_op/spectre/schematic" )
modelFile(
    '("/home/hoangtrang/Thu_vien_PDK/PDK_CRN65LP_v1.7a_Official_IC61_20120914_all/PDK_CRN65LP_v1.7a_Official_IC61_20120914/tsmcN65/../models/spectre/toplevel.scs" "tt_lib")
)

fin=infile("./OTA_para.txt")

fscanf(fin "\n%s" Cc_1_var	)
fscanf(fin "\n%s" Cc_2_var	)
fscanf(fin "\n%s" Cc_3_var	)
fscanf(fin "\n%s" Cc_4_var	)
fscanf(fin "\n%s" Cc_5_var	)
fscanf(fin "\n%s" Cc_6_var	)
fscanf(fin "\n%s" Cc_7_var	)
fscanf(fin "\n%s" Cc_8_var	)
fscanf(fin "\n%s" LM12345_1_var	)
fscanf(fin "\n%s" LM12345_2_var	)
fscanf(fin "\n%s" LM12345_3_var	)
fscanf(fin "\n%s" LM12345_4_var	)
fscanf(fin "\n%s" LM12345_5_var	)
fscanf(fin "\n%s" LM12345_6_var	)
fscanf(fin "\n%s" LM12345_7_var	)
fscanf(fin "\n%s" LM12345_8_var	)
fscanf(fin "\n%s" LM68_1_var	)
fscanf(fin "\n%s" LM68_2_var	)
fscanf(fin "\n%s" LM68_3_var	)
fscanf(fin "\n%s" LM68_4_var	)
fscanf(fin "\n%s" LM68_5_var	)
fscanf(fin "\n%s" LM68_6_var	)
fscanf(fin "\n%s" LM68_7_var	)
fscanf(fin "\n%s" LM68_8_var	)
fscanf(fin "\n%s" LM79_1_var	)
fscanf(fin "\n%s" LM79_2_var	)
fscanf(fin "\n%s" LM79_3_var	)
fscanf(fin "\n%s" LM79_4_var	)
fscanf(fin "\n%s" LM79_5_var	)
fscanf(fin "\n%s" LM79_6_var	)
fscanf(fin "\n%s" LM79_7_var	)
fscanf(fin "\n%s" LM79_8_var	)
fscanf(fin "\n%s" LMN8_1_var	)
fscanf(fin "\n%s" LMN8_2_var	)
fscanf(fin "\n%s" LMN8_3_var	)
fscanf(fin "\n%s" LMN8_4_var	)
fscanf(fin "\n%s" LMN8_5_var	)
fscanf(fin "\n%s" LMN8_6_var	)
fscanf(fin "\n%s" LMN8_7_var	)
fscanf(fin "\n%s" LMN8_8_var	)
fscanf(fin "\n%s" LMP1_1_var	)
fscanf(fin "\n%s" LMP1_2_var	)
fscanf(fin "\n%s" LMP1_3_var	)
fscanf(fin "\n%s" LMP1_4_var	)
fscanf(fin "\n%s" LMP1_5_var	)
fscanf(fin "\n%s" LMP1_6_var	)
fscanf(fin "\n%s" LMP1_7_var	)
fscanf(fin "\n%s" LMP1_8_var	)
fscanf(fin "\n%s" LMP2_1_var	)
fscanf(fin "\n%s" LMP2_2_var	)
fscanf(fin "\n%s" LMP2_3_var	)
fscanf(fin "\n%s" LMP2_4_var	)
fscanf(fin "\n%s" LMP2_5_var	)
fscanf(fin "\n%s" LMP2_6_var	)
fscanf(fin "\n%s" LMP2_7_var	)
fscanf(fin "\n%s" LMP2_8_var	)
fscanf(fin "\n%s" LMP5_1_var	)
fscanf(fin "\n%s" LMP5_2_var	)
fscanf(fin "\n%s" LMP5_3_var	)
fscanf(fin "\n%s" LMP5_4_var	)
fscanf(fin "\n%s" LMP5_5_var	)
fscanf(fin "\n%s" LMP5_6_var	)
fscanf(fin "\n%s" LMP5_7_var	)
fscanf(fin "\n%s" LMP5_8_var	)
fscanf(fin "\n%s" WM12345_1_var	)
fscanf(fin "\n%s" WM12345_2_var	)
fscanf(fin "\n%s" WM12345_3_var	)
fscanf(fin "\n%s" WM12345_4_var	)
fscanf(fin "\n%s" WM12345_5_var	)
fscanf(fin "\n%s" WM12345_6_var	)
fscanf(fin "\n%s" WM12345_7_var	)
fscanf(fin "\n%s" WM12345_8_var	)
fscanf(fin "\n%s" WM68_1_var	)
fscanf(fin "\n%s" WM68_2_var	)
fscanf(fin "\n%s" WM68_3_var	)
fscanf(fin "\n%s" WM68_4_var	)
fscanf(fin "\n%s" WM68_5_var	)
fscanf(fin "\n%s" WM68_6_var	)
fscanf(fin "\n%s" WM68_7_var	)
fscanf(fin "\n%s" WM68_8_var	)
fscanf(fin "\n%s" WM79_1_var	)
fscanf(fin "\n%s" WM79_2_var	)
fscanf(fin "\n%s" WM79_3_var	)
fscanf(fin "\n%s" WM79_4_var	)
fscanf(fin "\n%s" WM79_5_var	)
fscanf(fin "\n%s" WM79_6_var	)
fscanf(fin "\n%s" WM79_7_var	)
fscanf(fin "\n%s" WM79_8_var	)
fscanf(fin "\n%s" WMN8_1_var	)
fscanf(fin "\n%s" WMN8_2_var	)
fscanf(fin "\n%s" WMN8_3_var	)
fscanf(fin "\n%s" WMN8_4_var	)
fscanf(fin "\n%s" WMN8_5_var	)
fscanf(fin "\n%s" WMN8_6_var	)
fscanf(fin "\n%s" WMN8_7_var	)
fscanf(fin "\n%s" WMN8_8_var	)
fscanf(fin "\n%s" WMP1_1_var	)
fscanf(fin "\n%s" WMP1_2_var	)
fscanf(fin "\n%s" WMP1_3_var	)
fscanf(fin "\n%s" WMP1_4_var	)
fscanf(fin "\n%s" WMP1_5_var	)
fscanf(fin "\n%s" WMP1_6_var	)
fscanf(fin "\n%s" WMP1_7_var	)
fscanf(fin "\n%s" WMP1_8_var	)
fscanf(fin "\n%s" WMP2_1_var	)
fscanf(fin "\n%s" WMP2_2_var	)
fscanf(fin "\n%s" WMP2_3_var	)
fscanf(fin "\n%s" WMP2_4_var	)
fscanf(fin "\n%s" WMP2_5_var	)
fscanf(fin "\n%s" WMP2_6_var	)
fscanf(fin "\n%s" WMP2_7_var	)
fscanf(fin "\n%s" WMP2_8_var	)
fscanf(fin "\n%s" WMP5_1_var	)
fscanf(fin "\n%s" WMP5_2_var	)
fscanf(fin "\n%s" WMP5_3_var	)
fscanf(fin "\n%s" WMP5_4_var	)
fscanf(fin "\n%s" WMP5_5_var	)
fscanf(fin "\n%s" WMP5_6_var	)
fscanf(fin "\n%s" WMP5_7_var	)
fscanf(fin "\n%s" WMP5_8_var	)

close(fin)

)

(procedure chay()
analysis('dc ?saveOppoint t  )
analysis('ac ?start "1"  ?stop "2G"  ?dec "100"  )
analysis('tran ?stop "2m"  )

desVar(	  "Cc_1" Cc_1_var	)
desVar(	  "Cc_2" Cc_2_var	)
desVar(	  "Cc_3" Cc_3_var	)
desVar(	  "Cc_4" Cc_4_var	)
desVar(	  "Cc_5" Cc_5_var	)
desVar(	  "Cc_6" Cc_6_var	)
desVar(	  "Cc_7" Cc_7_var	)
desVar(	  "Cc_8" Cc_8_var	)
desVar(	  "LM12345_1" LM12345_1_var	)
desVar(	  "LM12345_2" LM12345_2_var	)
desVar(	  "LM12345_3" LM12345_3_var	)
desVar(	  "LM12345_4" LM12345_4_var	)
desVar(	  "LM12345_5" LM12345_5_var	)
desVar(	  "LM12345_6" LM12345_6_var	)
desVar(	  "LM12345_7" LM12345_7_var	)
desVar(	  "LM12345_8" LM12345_8_var	)
desVar(	  "LM68_1" LM68_1_var	)
desVar(	  "LM68_2" LM68_2_var	)
desVar(	  "LM68_3" LM68_3_var	)
desVar(	  "LM68_4" LM68_4_var	)
desVar(	  "LM68_5" LM68_5_var	)
desVar(	  "LM68_6" LM68_6_var	)
desVar(	  "LM68_7" LM68_7_var	)
desVar(	  "LM68_8" LM68_8_var	)
desVar(	  "LM79_1" LM79_1_var	)
desVar(	  "LM79_2" LM79_2_var	)
desVar(	  "LM79_3" LM79_3_var	)
desVar(	  "LM79_4" LM79_4_var	)
desVar(	  "LM79_5" LM79_5_var	)
desVar(	  "LM79_6" LM79_6_var	)
desVar(	  "LM79_7" LM79_7_var	)
desVar(	  "LM79_8" LM79_8_var	)
desVar(	  "LMN8_1" LMN8_1_var	)
desVar(	  "LMN8_2" LMN8_2_var	)
desVar(	  "LMN8_3" LMN8_3_var	)
desVar(	  "LMN8_4" LMN8_4_var	)
desVar(	  "LMN8_5" LMN8_5_var	)
desVar(	  "LMN8_6" LMN8_6_var	)
desVar(	  "LMN8_7" LMN8_7_var	)
desVar(	  "LMN8_8" LMN8_8_var	)
desVar(	  "LMP1_1" LMP1_1_var	)
desVar(	  "LMP1_2" LMP1_2_var	)
desVar(	  "LMP1_3" LMP1_3_var	)
desVar(	  "LMP1_4" LMP1_4_var	)
desVar(	  "LMP1_5" LMP1_5_var	)
desVar(	  "LMP1_6" LMP1_6_var	)
desVar(	  "LMP1_7" LMP1_7_var	)
desVar(	  "LMP1_8" LMP1_8_var	)
desVar(	  "LMP2_1" LMP2_1_var	)
desVar(	  "LMP2_2" LMP2_2_var	)
desVar(	  "LMP2_3" LMP2_3_var	)
desVar(	  "LMP2_4" LMP2_4_var	)
desVar(	  "LMP2_5" LMP2_5_var	)
desVar(	  "LMP2_6" LMP2_6_var	)
desVar(	  "LMP2_7" LMP2_7_var	)
desVar(	  "LMP2_8" LMP2_8_var	)
desVar(	  "LMP5_1" LMP5_1_var	)
desVar(	  "LMP5_2" LMP5_2_var	)
desVar(	  "LMP5_3" LMP5_3_var	)
desVar(	  "LMP5_4" LMP5_4_var	)
desVar(	  "LMP5_5" LMP5_5_var	)
desVar(	  "LMP5_6" LMP5_6_var	)
desVar(	  "LMP5_7" LMP5_7_var	)
desVar(	  "LMP5_8" LMP5_8_var	)
desVar(	  "Vcm" "1"	)
desVar(	  "Vdd" "2.4"	)
desVar(	  "Vss" "0"	)
desVar(	  "WM12345_1" WM12345_1_var	)
desVar(	  "WM12345_2" WM12345_2_var	)
desVar(	  "WM12345_3" WM12345_3_var	)
desVar(	  "WM12345_4" WM12345_4_var	)
desVar(	  "WM12345_5" WM12345_5_var	)
desVar(	  "WM12345_6" WM12345_6_var	)
desVar(	  "WM12345_7" WM12345_7_var	)
desVar(	  "WM12345_8" WM12345_8_var	)
desVar(	  "WM68_1" WM68_1_var	)
desVar(	  "WM68_2" WM68_2_var	)
desVar(	  "WM68_3" WM68_3_var	)
desVar(	  "WM68_4" WM68_4_var	)
desVar(	  "WM68_5" WM68_5_var	)
desVar(	  "WM68_6" WM68_6_var	)
desVar(	  "WM68_7" WM68_7_var	)
desVar(	  "WM68_8" WM68_8_var	)
desVar(	  "WM79_1" WM79_1_var	)
desVar(	  "WM79_2" WM79_2_var	)
desVar(	  "WM79_3" WM79_3_var	)
desVar(	  "WM79_4" WM79_4_var	)
desVar(	  "WM79_5" WM79_5_var	)
desVar(	  "WM79_6" WM79_6_var	)
desVar(	  "WM79_7" WM79_7_var	)
desVar(	  "WM79_8" WM79_8_var	)
desVar(	  "WMN8_1" WMN8_1_var	)
desVar(	  "WMN8_2" WMN8_2_var	)
desVar(	  "WMN8_3" WMN8_3_var	)
desVar(	  "WMN8_4" WMN8_4_var	)
desVar(	  "WMN8_5" WMN8_5_var	)
desVar(	  "WMN8_6" WMN8_6_var	)
desVar(	  "WMN8_7" WMN8_7_var	)
desVar(	  "WMN8_8" WMN8_8_var	)
desVar(	  "WMP1_1" WMP1_1_var	)
desVar(	  "WMP1_2" WMP1_2_var	)
desVar(	  "WMP1_3" WMP1_3_var	)
desVar(	  "WMP1_4" WMP1_4_var	)
desVar(	  "WMP1_5" WMP1_5_var	)
desVar(	  "WMP1_6" WMP1_6_var	)
desVar(	  "WMP1_7" WMP1_7_var	)
desVar(	  "WMP1_8" WMP1_8_var	)
desVar(	  "WMP2_1" WMP2_1_var	)
desVar(	  "WMP2_2" WMP2_2_var	)
desVar(	  "WMP2_3" WMP2_3_var	)
desVar(	  "WMP2_4" WMP2_4_var	)
desVar(	  "WMP2_5" WMP2_5_var	)
desVar(	  "WMP2_6" WMP2_6_var	)
desVar(	  "WMP2_7" WMP2_7_var	)
desVar(	  "WMP2_8" WMP2_8_var	)
desVar(	  "WMP5_1" WMP5_1_var	)
desVar(	  "WMP5_2" WMP5_2_var	)
desVar(	  "WMP5_3" WMP5_3_var	)
desVar(	  "WMP5_4" WMP5_4_var	)
desVar(	  "WMP5_5" WMP5_5_var	)
desVar(	  "WMP5_6" WMP5_6_var	)
desVar(	  "WMP5_7" WMP5_7_var	)
desVar(	  "WMP5_8" WMP5_8_var	)

envOption(
	'analysisOrder  list("tran" "dc" "ac")
)
saveOption( 'currents "all" )
saveOption( 'pwr "all" )
saveOption( 'save "all" )
temp( 27 )
run()

DcOp_MN1_1 = pv("I0.MN1_1" "region" ?result "dcOpInfo")
DcOp_MN2_1 = pv("I0.MN2_1" "region" ?result "dcOpInfo")
DcOp_MN3_1 = pv("I0.MN3_1" "region" ?result "dcOpInfo")
DcOp_MN4_1 = pv("I0.MN4_1" "region" ?result "dcOpInfo")
DcOp_MN5_1 = pv("I0.MN5_1" "region" ?result "dcOpInfo")
DcOp_MN7_1 = pv("I0.MN7_1" "region" ?result "dcOpInfo")
DcOp_MN8_1 = pv("I0.MN8_1" "region" ?result "dcOpInfo")
DcOp_MN9_1 = pv("I0.MN9_1" "region" ?result "dcOpInfo")
DcOp_MP1_1 = pv("I0.MP1_1" "region" ?result "dcOpInfo")
DcOp_MP2_1 = pv("I0.MP2_1" "region" ?result "dcOpInfo")
DcOp_MP5_1 = pv("I0.MP5_1" "region" ?result "dcOpInfo")
DcOp_MP6_1 = pv("I0.MP6_1" "region" ?result "dcOpInfo")
DcOp_MP8_1 = pv("I0.MP8_1" "region" ?result "dcOpInfo")

;OTA_2 I1
DcOp_MN1_2 = pv("I1.MN1_2" "region" ?result "dcOpInfo")
DcOp_MN2_2 = pv("I1.MN2_2" "region" ?result "dcOpInfo")
DcOp_MN3_2 = pv("I1.MN3_2" "region" ?result "dcOpInfo")
DcOp_MN4_2 = pv("I1.MN4_2" "region" ?result "dcOpInfo")
DcOp_MN5_2 = pv("I1.MN5_2" "region" ?result "dcOpInfo")
DcOp_MN7_2 = pv("I1.MN7_2" "region" ?result "dcOpInfo")
DcOp_MN8_2 = pv("I1.MN8_2" "region" ?result "dcOpInfo")
DcOp_MN9_2 = pv("I1.MN9_2" "region" ?result "dcOpInfo")
DcOp_MP1_2 = pv("I1.MP1_2" "region" ?result "dcOpInfo")
DcOp_MP2_2 = pv("I1.MP2_2" "region" ?result "dcOpInfo")
DcOp_MP5_2 = pv("I1.MP5_2" "region" ?result "dcOpInfo")
DcOp_MP6_2 = pv("I1.MP6_2" "region" ?result "dcOpInfo")
DcOp_MP8_2 = pv("I1.MP8_2" "region" ?result "dcOpInfo")

;OTA_3 I2
DcOp_MN1_3 = pv("I2.MN1_3" "region" ?result "dcOpInfo")
DcOp_MN2_3 = pv("I2.MN2_3" "region" ?result "dcOpInfo")
DcOp_MN3_3 = pv("I2.MN3_3" "region" ?result "dcOpInfo")
DcOp_MN4_3 = pv("I2.MN4_3" "region" ?result "dcOpInfo")
DcOp_MN5_3 = pv("I2.MN5_3" "region" ?result "dcOpInfo")
DcOp_MN7_3 = pv("I2.MN7_3" "region" ?result "dcOpInfo")
DcOp_MN8_3 = pv("I2.MN8_3" "region" ?result "dcOpInfo")
DcOp_MN9_3 = pv("I2.MN9_3" "region" ?result "dcOpInfo")
DcOp_MP1_3 = pv("I2.MP1_3" "region" ?result "dcOpInfo")
DcOp_MP2_3 = pv("I2.MP2_3" "region" ?result "dcOpInfo")
DcOp_MP5_3 = pv("I2.MP5_3" "region" ?result "dcOpInfo")
DcOp_MP6_3 = pv("I2.MP6_3" "region" ?result "dcOpInfo")
DcOp_MP8_3 = pv("I2.MP8_3" "region" ?result "dcOpInfo")

;OTA_4 I16
DcOp_MN1_4 = pv("I16.MN1_4" "region" ?result "dcOpInfo")
DcOp_MN2_4 = pv("I16.MN2_4" "region" ?result "dcOpInfo")
DcOp_MN3_4 = pv("I16.MN3_4" "region" ?result "dcOpInfo")
DcOp_MN4_4 = pv("I16.MN4_4" "region" ?result "dcOpInfo")
DcOp_MN5_4 = pv("I16.MN5_4" "region" ?result "dcOpInfo")
DcOp_MN7_4 = pv("I16.MN7_4" "region" ?result "dcOpInfo")
DcOp_MN8_4 = pv("I16.MN8_4" "region" ?result "dcOpInfo")
DcOp_MN9_4 = pv("I16.MN9_4" "region" ?result "dcOpInfo")
DcOp_MP1_4 = pv("I16.MP1_4" "region" ?result "dcOpInfo")
DcOp_MP2_4 = pv("I16.MP2_4" "region" ?result "dcOpInfo")
DcOp_MP5_4 = pv("I16.MP5_4" "region" ?result "dcOpInfo")
DcOp_MP6_4 = pv("I16.MP6_4" "region" ?result "dcOpInfo")
DcOp_MP8_4 = pv("I16.MP8_4" "region" ?result "dcOpInfo")

;OTA_5 I4
DcOp_MN1_5 = pv("I4.MN1_5" "region" ?result "dcOpInfo")
DcOp_MN2_5 = pv("I4.MN2_5" "region" ?result "dcOpInfo")
DcOp_MN3_5 = pv("I4.MN3_5" "region" ?result "dcOpInfo")
DcOp_MN4_5 = pv("I4.MN4_5" "region" ?result "dcOpInfo")
DcOp_MN5_5 = pv("I4.MN5_5" "region" ?result "dcOpInfo")
DcOp_MN7_5 = pv("I4.MN7_5" "region" ?result "dcOpInfo")
DcOp_MN8_5 = pv("I4.MN8_5" "region" ?result "dcOpInfo")
DcOp_MN9_5 = pv("I4.MN9_5" "region" ?result "dcOpInfo")
DcOp_MP1_5 = pv("I4.MP1_5" "region" ?result "dcOpInfo")
DcOp_MP2_5 = pv("I4.MP2_5" "region" ?result "dcOpInfo")
DcOp_MP5_5 = pv("I4.MP5_5" "region" ?result "dcOpInfo")
DcOp_MP6_5 = pv("I4.MP6_5" "region" ?result "dcOpInfo")
DcOp_MP8_5 = pv("I4.MP8_5" "region" ?result "dcOpInfo")

;OTA_6 I5
DcOp_MN1_6 = pv("I5.MN1_6" "region" ?result "dcOpInfo")
DcOp_MN2_6 = pv("I5.MN2_6" "region" ?result "dcOpInfo")
DcOp_MN3_6 = pv("I5.MN3_6" "region" ?result "dcOpInfo")
DcOp_MN4_6 = pv("I5.MN4_6" "region" ?result "dcOpInfo")
DcOp_MN5_6 = pv("I5.MN5_6" "region" ?result "dcOpInfo")
DcOp_MN7_6 = pv("I5.MN7_6" "region" ?result "dcOpInfo")
DcOp_MN8_6 = pv("I5.MN8_6" "region" ?result "dcOpInfo")
DcOp_MN9_6 = pv("I5.MN9_6" "region" ?result "dcOpInfo")
DcOp_MP1_6 = pv("I5.MP1_6" "region" ?result "dcOpInfo")
DcOp_MP2_6 = pv("I5.MP2_6" "region" ?result "dcOpInfo")
DcOp_MP5_6 = pv("I5.MP5_6" "region" ?result "dcOpInfo")
DcOp_MP6_6 = pv("I5.MP6_6" "region" ?result "dcOpInfo")
DcOp_MP8_6 = pv("I5.MP8_6" "region" ?result "dcOpInfo")

;OTA_7 I6
DcOp_MN1_7 = pv("I6.MN1_7" "region" ?result "dcOpInfo")
DcOp_MN2_7 = pv("I6.MN2_7" "region" ?result "dcOpInfo")
DcOp_MN3_7 = pv("I6.MN3_7" "region" ?result "dcOpInfo")
DcOp_MN4_7 = pv("I6.MN4_7" "region" ?result "dcOpInfo")
DcOp_MN5_7 = pv("I6.MN5_7" "region" ?result "dcOpInfo")
DcOp_MN7_7 = pv("I6.MN7_7" "region" ?result "dcOpInfo")
DcOp_MN8_7 = pv("I6.MN8_7" "region" ?result "dcOpInfo")
DcOp_MN9_7 = pv("I6.MN9_7" "region" ?result "dcOpInfo")
DcOp_MP1_7 = pv("I6.MP1_7" "region" ?result "dcOpInfo")
DcOp_MP2_7 = pv("I6.MP2_7" "region" ?result "dcOpInfo")
DcOp_MP5_7 = pv("I6.MP5_7" "region" ?result "dcOpInfo")
DcOp_MP6_7 = pv("I6.MP6_7" "region" ?result "dcOpInfo")
DcOp_MP8_7 = pv("I6.MP8_7" "region" ?result "dcOpInfo")

;OTA_8 I7
DcOp_MN1_8 = pv("I7.MN1_8" "region" ?result "dcOpInfo")
DcOp_MN2_8 = pv("I7.MN2_8" "region" ?result "dcOpInfo")
DcOp_MN3_8 = pv("I7.MN3_8" "region" ?result "dcOpInfo")
DcOp_MN4_8 = pv("I7.MN4_8" "region" ?result "dcOpInfo")
DcOp_MN5_8 = pv("I7.MN5_8" "region" ?result "dcOpInfo")
DcOp_MN7_8 = pv("I7.MN7_8" "region" ?result "dcOpInfo")
DcOp_MN8_8 = pv("I7.MN8_8" "region" ?result "dcOpInfo")
DcOp_MN9_8 = pv("I7.MN9_8" "region" ?result "dcOpInfo")
DcOp_MP1_8 = pv("I7.MP1_8" "region" ?result "dcOpInfo")
DcOp_MP2_8 = pv("I7.MP2_8" "region" ?result "dcOpInfo")
DcOp_MP5_8 = pv("I7.MP5_8" "region" ?result "dcOpInfo")
DcOp_MP6_8 = pv("I7.MP6_8" "region" ?result "dcOpInfo")
DcOp_MP8_8 = pv("I7.MP8_8" "region" ?result "dcOpInfo")

if(((DcOp_MN1_1 == 2)&&(DcOp_MN2_1 == 2)&&(DcOp_MN3_1 == 2)&&(DcOp_MN4_1 == 2)&&(DcOp_MN5_1 == 2)&&(DcOp_MN7_1 == 2)&&(DcOp_MN8_1 == 2)&&(DcOp_MN9_1 == 2)&&(DcOp_MP1_1 == 2)&&(DcOp_MP2_1 == 2)&&(DcOp_MP5_1 == 2)&&(DcOp_MP6_1 == 2)&&(DcOp_MP8_1 == 2)!= 0) then cond_1 = 1 else cond_1 = 0)
if(((DcOp_MN1_2 == 2)&&(DcOp_MN2_2 == 2)&&(DcOp_MN3_2 == 2)&&(DcOp_MN4_2 == 2)&&(DcOp_MN5_2 == 2)&&(DcOp_MN7_2 == 2)&&(DcOp_MN8_2 == 2)&&(DcOp_MN9_2 == 2)&&(DcOp_MP1_2 == 2)&&(DcOp_MP2_2 == 2)&&(DcOp_MP5_2 == 2)&&(DcOp_MP6_2 == 2)&&(DcOp_MP8_2 == 2)!= 0) then cond_2 = 1 else cond_2 = 0)
if(((DcOp_MN1_3 == 2)&&(DcOp_MN2_3 == 2)&&(DcOp_MN3_3 == 2)&&(DcOp_MN4_3 == 2)&&(DcOp_MN5_3 == 2)&&(DcOp_MN7_3 == 2)&&(DcOp_MN8_3 == 2)&&(DcOp_MN9_3 == 2)&&(DcOp_MP1_3 == 2)&&(DcOp_MP2_3 == 2)&&(DcOp_MP5_3 == 2)&&(DcOp_MP6_3 == 2)&&(DcOp_MP8_3 == 2)!= 0) then cond_3 = 1 else cond_3 = 0)
if(((DcOp_MN1_4 == 2)&&(DcOp_MN2_4 == 2)&&(DcOp_MN3_4 == 2)&&(DcOp_MN4_4 == 2)&&(DcOp_MN5_4 == 2)&&(DcOp_MN7_4 == 2)&&(DcOp_MN8_4 == 2)&&(DcOp_MN9_4 == 2)&&(DcOp_MP1_4 == 2)&&(DcOp_MP2_4 == 2)&&(DcOp_MP5_4 == 2)&&(DcOp_MP6_4 == 2)&&(DcOp_MP8_4 == 2)!= 0) then cond_4 = 1 else cond_4 = 0)
if(((DcOp_MN1_5 == 2)&&(DcOp_MN2_5 == 2)&&(DcOp_MN3_5 == 2)&&(DcOp_MN4_5 == 2)&&(DcOp_MN5_5 == 2)&&(DcOp_MN7_5 == 2)&&(DcOp_MN8_5 == 2)&&(DcOp_MN9_5 == 2)&&(DcOp_MP1_5 == 2)&&(DcOp_MP2_5 == 2)&&(DcOp_MP5_5 == 2)&&(DcOp_MP6_5 == 2)&&(DcOp_MP8_5 == 2)!= 0) then cond_5 = 1 else cond_5 = 0)
if(((DcOp_MN1_6 == 2)&&(DcOp_MN2_6 == 2)&&(DcOp_MN3_6 == 2)&&(DcOp_MN4_6 == 2)&&(DcOp_MN5_6 == 2)&&(DcOp_MN7_6 == 2)&&(DcOp_MN8_6 == 2)&&(DcOp_MN9_6 == 2)&&(DcOp_MP1_6 == 2)&&(DcOp_MP2_6 == 2)&&(DcOp_MP5_6 == 2)&&(DcOp_MP6_6 == 2)&&(DcOp_MP8_6 == 2)!= 0) then cond_6 = 1 else cond_6 = 0)
if(((DcOp_MN1_7 == 2)&&(DcOp_MN2_7 == 2)&&(DcOp_MN3_7 == 2)&&(DcOp_MN4_7 == 2)&&(DcOp_MN5_7 == 2)&&(DcOp_MN7_7 == 2)&&(DcOp_MN8_7 == 2)&&(DcOp_MN9_7 == 2)&&(DcOp_MP1_7 == 2)&&(DcOp_MP2_7 == 2)&&(DcOp_MP5_7 == 2)&&(DcOp_MP6_7 == 2)&&(DcOp_MP8_7 == 2)!= 0) then cond_7 = 1 else cond_7 = 0)
if(((DcOp_MN1_8 == 2)&&(DcOp_MN2_8 == 2)&&(DcOp_MN3_8 == 2)&&(DcOp_MN4_8 == 2)&&(DcOp_MN5_8 == 2)&&(DcOp_MN7_8 == 2)&&(DcOp_MN8_8 == 2)&&(DcOp_MN9_8 == 2)&&(DcOp_MP1_8 == 2)&&(DcOp_MP2_8 == 2)&&(DcOp_MP5_8 == 2)&&(DcOp_MP6_8 == 2)&&(DcOp_MP8_8 == 2)!= 0) then cond_8 = 1 else cond_8 = 0)

GBW_1 = cross(dB20((VF("/vout1") / VF("/vinp"))) 0 1 "either" nil nil)
GBW_2 = cross(dB20((VF("/vout2") / VF("/vinp"))) 0 1 "either" nil nil)
GBW_3 = cross(dB20((VF("/vout3") / VF("/vinp"))) 0 1 "either" nil nil)
GBW_4 = cross(dB20((VF("/vout4") / VF("/vinp"))) 0 1 "either" nil nil)
GBW_5 = cross(dB20((VF("/vout5") / VF("/vinp"))) 0 1 "either" nil nil)
GBW_6 = cross(dB20((VF("/vout6") / VF("/vinp"))) 0 1 "either" nil nil)
GBW_7 = cross(dB20((VF("/vout7") / VF("/vinp"))) 0 1 "either" nil nil)
GBW_8 = cross(dB20((VF("/vout8") / VF("/vinp"))) 0 1 "either" nil nil)

Gain_1 = value(dB20((VF("/vout1") / VF("/vinp"))) 100)
Gain_2 = value(dB20((VF("/vout2") / VF("/vinp"))) 100)
Gain_3 = value(dB20((VF("/vout3") / VF("/vinp"))) 100)
Gain_4 = value(dB20((VF("/vout4") / VF("/vinp"))) 100)
Gain_5 = value(dB20((VF("/vout5") / VF("/vinp"))) 100)
Gain_6 = value(dB20((VF("/vout6") / VF("/vinp"))) 100)
Gain_7 = value(dB20((VF("/vout7") / VF("/vinp"))) 100)
Gain_8 = value(dB20((VF("/vout8") / VF("/vinp"))) 100)

PM_1 = phaseMargin(VF("/vout1"))
PM_2 = phaseMargin(VF("/vout2"))
PM_3 = phaseMargin(VF("/vout3"))
PM_4 = phaseMargin(VF("/vout4"))
PM_5 = phaseMargin(VF("/vout5"))
PM_6 = phaseMargin(VF("/vout6"))
PM_7 = phaseMargin(VF("/vout7"))
PM_8 = phaseMargin(VF("/vout8"))

SR_1 = slewRate(VT("/voutsr1") ymin(VT("/voutsr1")) nil ymax(VT("/voutsr1")) nil 10 90 nil "time")
SR_2 = slewRate(VT("/voutsr2") ymin(VT("/voutsr2")) nil ymax(VT("/voutsr2")) nil 10 90 nil "time")
SR_3 = slewRate(VT("/voutsr3") ymin(VT("/voutsr3")) nil ymax(VT("/voutsr3")) nil 10 90 nil "time")
SR_4 = slewRate(VT("/voutsr4") ymin(VT("/voutsr4")) nil ymax(VT("/voutsr4")) nil 10 90 nil "time")
SR_5 = slewRate(VT("/voutsr5") ymin(VT("/voutsr5")) nil ymax(VT("/voutsr5")) nil 10 90 nil "time")
SR_6 = slewRate(VT("/voutsr6") ymin(VT("/voutsr6")) nil ymax(VT("/voutsr6")) nil 10 90 nil "time")
SR_7 = slewRate(VT("/voutsr7") ymin(VT("/voutsr7")) nil ymax(VT("/voutsr7")) nil 10 90 nil "time")
SR_8 = slewRate(VT("/voutsr8") ymin(VT("/voutsr8")) nil ymax(VT("/voutsr8")) nil 10 90 nil "time")

PWR_1 = getData("I0:pwr" ?result "dcOp")
PWR_2 = getData("I1:pwr" ?result "dcOp")
PWR_3 = getData("I2:pwr" ?result "dcOp")
PWR_4 = getData("I16:pwr" ?result "dcOp")
PWR_5 = getData("I4:pwr" ?result "dcOp")
PWR_6 = getData("I5:pwr" ?result "dcOp")
PWR_7 = getData("I6:pwr" ?result "dcOp")
PWR_8 = getData("I7:pwr" ?result "dcOp")

fileresult=outfile("./Result.txt")
  fprintf(fileresult "%d\r" cond_1)
  fprintf(fileresult "%d\r" cond_2)
  fprintf(fileresult "%d\r" cond_3)
  fprintf(fileresult "%d\r" cond_4)
  fprintf(fileresult "%d\r" cond_5)
  fprintf(fileresult "%d\r" cond_6)
  fprintf(fileresult "%d\r" cond_7)
  fprintf(fileresult "%d\r" cond_8)
  fprintf(fileresult "%1.15f\r" GBW_1)
  fprintf(fileresult "%1.15f\r" GBW_2)
  fprintf(fileresult "%1.15f\r" GBW_3)
  fprintf(fileresult "%1.15f\r" GBW_4)
  fprintf(fileresult "%1.15f\r" GBW_5)
  fprintf(fileresult "%1.15f\r" GBW_6)
  fprintf(fileresult "%1.15f\r" GBW_7)
  fprintf(fileresult "%1.15f\r" GBW_8)
  fprintf(fileresult "%1.15f\r" PM_1)
  fprintf(fileresult "%1.15f\r" PM_2)
  fprintf(fileresult "%1.15f\r" PM_3)
  fprintf(fileresult "%1.15f\r" PM_4)
  fprintf(fileresult "%1.15f\r" PM_5)
  fprintf(fileresult "%1.15f\r" PM_6)
  fprintf(fileresult "%1.15f\r" PM_7)
  fprintf(fileresult "%1.15f\r" PM_8)
  fprintf(fileresult "%1.15f\r" Gain_1)
  fprintf(fileresult "%1.15f\r" Gain_2)
  fprintf(fileresult "%1.15f\r" Gain_3)
  fprintf(fileresult "%1.15f\r" Gain_4)
  fprintf(fileresult "%1.15f\r" Gain_5)
  fprintf(fileresult "%1.15f\r" Gain_6)
  fprintf(fileresult "%1.15f\r" Gain_7)
  fprintf(fileresult "%1.15f\r" Gain_8)
  fprintf(fileresult "%1.15f\r" SR_1)
  fprintf(fileresult "%1.15f\r" SR_2)
  fprintf(fileresult "%1.15f\r" SR_3)
  fprintf(fileresult "%1.15f\r" SR_4)
  fprintf(fileresult "%1.15f\r" SR_5)
  fprintf(fileresult "%1.15f\r" SR_6)
  fprintf(fileresult "%1.15f\r" SR_7)
  fprintf(fileresult "%1.15f\r" SR_8)
  fprintf(fileresult "%1.15f\r" PWR_1)
  fprintf(fileresult "%1.15f\r" PWR_2)
  fprintf(fileresult "%1.15f\r" PWR_3)
  fprintf(fileresult "%1.15f\r" PWR_4)
  fprintf(fileresult "%1.15f\r" PWR_5)
  fprintf(fileresult "%1.15f\r" PWR_6)
  fprintf(fileresult "%1.15f\r" PWR_7)
  fprintf(fileresult "%1.15f\r" PWR_8)
close(fileresult)

)

khoitao()
chay()
;exit
